spice-lc-filter
V1 n2 n1 AC 2
V2 n1 0 DC 12
L1 n2 n3 100m
L2 n3 out 250m
C1 n3 0 100u
RL out 0 1k
.options reltol=1e-8 abstol=1e-12 vntol=1e-10 temp=27 tnom=27
.control
set noaskquit
set numdgt=15
ac lin 1 1000 1000
let m_v = mag(v(out))
print m_v
quit
.endc
.end
