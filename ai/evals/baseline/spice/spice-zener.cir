spice-zener
V1 in 0 12
R1 in out 1000
D1 0 out ZM
.model ZM D(IS=1e-14 BV=5.1 IBV=1m)
.options reltol=1e-8 abstol=1e-12 vntol=1e-10 temp=27 tnom=27
.control
set noaskquit
set numdgt=15
op
let m_v = v(out)
print m_v
let m_i = (v(in)-v(out))/1000
print m_i
quit
.endc
.end
