spice-multi-source
V1 n1 0 20
V2 n3 0 7
R1 n1 n2 10k
R2 n2 n3 8.1k
R3 n2 0 4.7k
.options reltol=1e-8 abstol=1e-12 vntol=1e-10 temp=27 tnom=27
.control
set noaskquit
set numdgt=15
op
let m_v = v(n2)
print m_v
let m_i1 = -i(v1)
print m_i1
quit
.endc
.end
