spice-rl-fall
V1 in 0 0
R1 in out 100
L1 out 0 10m IC=50m
.options reltol=1e-8 abstol=1e-12 vntol=1e-10 temp=27 tnom=27
.control
set noaskquit
set numdgt=15
tran 1u 1m uic
meas tran measured_m_i FIND i(L1) AT=100u
let m_i = measured_m_i
print m_i
quit
.endc
.end
