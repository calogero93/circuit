spice-rl-rise
V1 in 0 PULSE(0 5 0 1n 1n 10m 20m)
R1 in out 100
L1 out 0 10m IC=0
.options reltol=1e-8 abstol=1e-12 vntol=1e-10 temp=27 tnom=27
.control
set noaskquit
set numdgt=15
tran 1u 1m uic
meas tran measured_m_i FIND i(L1) AT=100u
let m_i = measured_m_i
print m_i
meas tran measured_m_v FIND v(out) AT=100u
let m_v = measured_m_v
print m_v
quit
.endc
.end
