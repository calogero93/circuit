spice-transformer
V1 in 0 AC 24
RS in p 1m
LP p 0 25
LS s ret 1
K1 LP LS .998
RL s ret 2k
RG ret 0 1e10
.options reltol=1e-8 abstol=1e-12 vntol=1e-10 temp=27 tnom=27
.control
set noaskquit
set numdgt=15
ac lin 1 1000 1000
let m_v = mag(v(s)-v(ret))
print m_v
quit
.endc
.end
