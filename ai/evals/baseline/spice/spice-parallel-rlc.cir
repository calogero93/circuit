spice-parallel-rlc
I1 0 out AC 1
R1 out 0 100
L1 out 0 10m
C1 out 0 2.533029591u
.options reltol=1e-8 abstol=1e-12 vntol=1e-10 temp=27 tnom=27
.control
set noaskquit
set numdgt=15
ac lin 1 1000 1000
let m_v = mag(v(out))
print m_v
let m_ir = mag(v(out)/100)
print m_ir
quit
.endc
.end
