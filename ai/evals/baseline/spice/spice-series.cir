spice-series
V1 in 0 12
R1 in n1 100
R2 n1 n2 220
R3 n2 0 330
.options reltol=1e-8 abstol=1e-12 vntol=1e-10 temp=27 tnom=27
.control
set noaskquit
set numdgt=15
op
let m_i = -i(v1)
print m_i
let m_v2 = v(n1)-v(n2)
print m_v2
let m_v3 = v(n2)
print m_v3
quit
.endc
.end
