spice-rc-cascade
V1 in 0 AC 1
R1 in n1 1k
C1 n1 0 100n
R2 n1 out 1k
C2 out 0 100n
.options reltol=1e-8 abstol=1e-12 vntol=1e-10 temp=27 tnom=27
.control
set noaskquit
set numdgt=15
ac lin 1 1000 1000
let m_v = mag(v(out))
print m_v
let m_phase = 180*ph(v(out))/3.141592653589793
print m_phase
quit
.endc
.end
