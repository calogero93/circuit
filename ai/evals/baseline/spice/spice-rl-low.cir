spice-rl-low
V1 in 0 AC 1
L1 in out 10m
R1 out 0 100
.options reltol=1e-8 abstol=1e-12 vntol=1e-10 temp=27 tnom=27
.control
set noaskquit
set numdgt=15
ac lin 1 1591.5494309189535 1591.5494309189535
let m_v = mag(v(out))
print m_v
let m_phase = 180*ph(v(out))/3.141592653589793
print m_phase
quit
.endc
.end
