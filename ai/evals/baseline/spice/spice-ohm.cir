spice-ohm
V1 in 0 5
R1 in 0 220
.options reltol=1e-8 abstol=1e-12 vntol=1e-10 temp=27 tnom=27
.control
set noaskquit
set numdgt=15
op
let m_i = -i(v1)
print m_i
let m_p = v(in)*(-i(v1))
print m_p
quit
.endc
.end
