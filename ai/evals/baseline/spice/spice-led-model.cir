spice-led-model
V1 in 0 5
R1 in out 330
D1 out 0 LEDM
.model LEDM D(IS=1e-20 N=2)
.options reltol=1e-8 abstol=1e-12 vntol=1e-10 temp=27 tnom=27
.control
set noaskquit
set numdgt=15
op
let m_v = v(out)
print m_v
let m_i = (v(in)-v(out))/330
print m_i
quit
.endc
.end
