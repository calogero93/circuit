spice-current-source
I1 0 out DC 0.01
R1 out 0 1000
R2 out 0 2000
.options reltol=1e-8 abstol=1e-12 vntol=1e-10 temp=27 tnom=27
.control
set noaskquit
set numdgt=15
op
let m_v = v(out)
print m_v
let m_i = v(out)/1000
print m_i
quit
.endc
.end
