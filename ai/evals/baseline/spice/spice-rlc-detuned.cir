spice-rlc-detuned
V1 in 0 AC 1
R1 in nr 100
L1 nr nc 10m
C1 nc 0 2.533029591u
.options reltol=1e-8 abstol=1e-12 vntol=1e-10 temp=27 tnom=27
.control
set noaskquit
set numdgt=15
ac lin 1 2000 2000
let m_v = mag(v(in)-v(nr))
print m_v
let m_i = mag((v(in)-v(nr))/100)
print m_i
quit
.endc
.end
