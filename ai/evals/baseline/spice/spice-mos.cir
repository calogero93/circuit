spice-mos
VDD vdd 0 5
VG g 0 2.5
RD vdd d 1k
M1 d g 0 0 NM W=20u L=10u
.model NM NMOS(LEVEL=1 VTO=1 KP=2m)
.options reltol=1e-8 abstol=1e-12 vntol=1e-10 temp=27 tnom=27
.control
set noaskquit
set numdgt=15
op
let m_v = v(d)
print m_v
let m_i = @m1[id]
print m_i
quit
.endc
.end
