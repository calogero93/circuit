spice-bjt
VCC vcc 0 12
RB vcc b 220k
RC vcc c 1k
Q1 c b 0 QM
.model QM NPN(IS=1e-15 BF=100 VAF=100)
.options reltol=1e-8 abstol=1e-12 vntol=1e-10 temp=27 tnom=27
.control
set noaskquit
set numdgt=15
op
let m_v = v(c)
print m_v
let m_ic = @q1[ic]
print m_ic
let m_ib = @q1[ib]
print m_ib
quit
.endc
.end
