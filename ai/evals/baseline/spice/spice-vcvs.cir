spice-vcvs
V1 in 0 2
E1 out 0 in 0 4
RL out 0 1000
.options reltol=1e-8 abstol=1e-12 vntol=1e-10 temp=27 tnom=27
.control
set noaskquit
set numdgt=15
op
let m_v = v(out)
print m_v
let m_i = v(out)/1000
print m_i
quit
.endc
.end
